# Ansys Electronics Desktop project, version 2022.2
materials:
  vacuum: permittivity=1
  pec: conductivity=1e+30
  air: permittivity=1.0006 permeability=1.0000004

design HFSSDesign1 (HFSS, DrivenModal, model units meter)
options: Calculate_Lossy_Dielectrics Save_Adaptive_support_files
geometry:
  Cylinder1 [pec] = cylinder(axis=Z, base_centre=(0meter, 0meter, 0.02meter), radius=0.01meter, height=1.326meter)
  Cylinder2 = cylinder(axis=Z, base_centre=(0meter, 0meter, -0.02meter), radius=0.01meter, height=-1.326meter)
  Cylinder3 = cylinder(axis=Z, base_centre=(0meter, 2.692meter, -1.346meter), radius=0.01meter, height=2.692meter)
  Cylinder4 = cylinder(axis=Y, base_centre=(0meter, 0meter, 1.346meter), radius=0.01meter, height=2.692meter)
  Sphere1 = sphere(centre=(0meter, 0meter, 1.346meter), radius=0.01meter)
  Sphere2 = sphere(centre=(0meter, 2.692meter, 1.346meter), radius=0.01meter)
  Cylinder5 = cylinder(axis=Y, base_centre=(0meter, 0meter, -1.346meter), radius=0.01meter, height=2.692meter)
  Sphere3 = sphere(centre=(0meter, 0meter, (0-1.346) meter), radius=0.01meter)
  Sphere4 = sphere(centre=(0meter, 2.692meter, -1.346meter), radius=0.01meter)
  Cylinder6 = cylinder(axis=Y, base_centre=(0meter, 0meter, 0.02meter), radius=0.01meter, height=-1.743meter)
  Sphere5 = sphere(centre=(0meter, 0meter, 0.02meter), radius=0.01meter)
  Cylinder7 = cylinder(axis=Y, base_centre=(0meter, 0meter, -0.02meter), radius=0.01meter, height=-1.743meter)
  Sphere6 = sphere(centre=(0meter, 0meter, -0.02meter), radius=0.01meter)
  Cylinder1.unite(Cylinder2..Cylinder7, Sphere1..Sphere6)
  Rectangle1 [pec] = rectangle(corner=(0meter, -1.743meter, -0.01meter), y_size=0.02meter, z_size=0.02meter)
  Box1 [air] = box(corner=(-3meter, -3meter, -4.5meter), size=(6meter, 9meter, 9meter))
boundaries and excitations:
  1: Lumped Port Objects=Rectangle1 Modes{Mode1{IntLine{(0, -1.733, -0.01) -> (0, -1.733, 0.01)} CharImp=Zpi RenormImp=50ohm}} Impedance=50ohm
setups:
  Setup1: HfssDriven Frequency=28MHz MaxDeltaS=0.02 MaximumPasses=10 MinimumPasses=1 MinimumConvergedPasses=1 PercentRefinement=30 BasisOrder=1 PortAccuracy=2 DrivenSolverType="Direct Solver"
    sweep Sweep: 1MHz to 40MHz step 0.1MHz; Type=Fast SaveFields
source amplitudes:
  1:1: 1W 0deg
reports:
  XY Plot 1: dB(S(1,1)) vs Freq on Setup1 : Sweep
